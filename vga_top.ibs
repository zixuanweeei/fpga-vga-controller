| / 7\'7
| \ \   Xilinx Inc.
| / /
| \_\/.\   IBIS Models for Spartan-3
| IBIS file spartan3.ibs created by appending individual files created
| using s2ibis2 version 1.1 North Carolina State University
| Electronics Research Laboratory 1995
[IBIS ver]   3.2
[File name]   vga_top.ibs
[File Rev]   3.4.4
[Date]   Sat Jun 06 16:11:28 2015
[Source]   Spartan-3 layout and silicon models.
[Notes]   Xilinx Spartan-3 I/O IBIS models.
   To accurately model package parasitics, please follow the
   instructions at:  http://www.xilinx.com/xlnx/
   xil_ans_display.jsp?getPagePath=11754
   LVDS and LVPECL drivers require the use of external
   termination resistors to provide the correct voltage levels.
   For more information, refer to the Spartan-3 documentation.
   NOTE: This file is compliant with IBIS Version 3.2, but it
   may not implement all approved 3.2 features.
   NOTE:  Newer versions of the buffer models may be available.
   Check the web (http://www.xilinx.com/support/sw_ibis.htm) for
   the latest file revision.  However, please be aware that the
   web files are not compatible for use with IBISWriter, and
   must be manually annotated, should their use be preferred.
[Disclaimer] The data in these models is derived from HSPICE simulations
                 using modeling information extracted from the target process.
                 While a great deal of care has been taken to provide
                 information that is accurate, this model is considered
                 PRELIMINARY as it has not been verified by actual silicon
                 measurement.
[Copyright]   Copyright 2004 Xilinx Inc., All rights reserved.
|   Component Spartan-3
[Component]   Spartan-3
[Manufacturer]   Xilinx, Inc.
[Package]
| For Package Type fg320
| variable   typ   min   max
R_pkg   0.10m   0.10m   0.10m
L_pkg   0.80nH   0.80nH   0.80nH
C_pkg   0.50pF   0.50pF   0.50pF
[Pin]  signal_name   model_name   R_pin   L_pin   C_pin
U10   blue<5>   LVCMOS25_S_12mA_O
R7   blue<6>   LVCMOS25_S_12mA_O
T5   blue<7>   LVCMOS25_S_12mA_O
V3   rst   LVCMOS25_S_12mA_I
T11   red<0>   LVCMOS25_S_12mA_O
V11   red<1>   LVCMOS25_S_12mA_O
T12   red<2>   LVCMOS25_S_12mA_O
P12   red<3>   LVCMOS25_S_12mA_O
V10   red<4>   LVCMOS25_S_12mA_O
U13   red<5>   LVCMOS25_S_12mA_O
P8   red<6>   LVCMOS25_S_12mA_O
T7   red<7>   LVCMOS25_S_12mA_O
P10   clk   LVCMOS25_S_12mA_I
V7   regNeg   LVCMOS25_S_12mA_I
R6   green<0>   LVCMOS25_S_12mA_O
T1   green<1>   LVCMOS25_S_12mA_O
U1   green<2>   LVCMOS25_S_12mA_O
R3   green<3>   LVCMOS25_S_12mA_O
R1   green<4>   LVCMOS25_S_12mA_O
R2   green<5>   LVCMOS25_S_12mA_O
V8   hsync   LVCMOS25_S_12mA_O
P3   green<6>   LVCMOS25_S_12mA_O
P7   green<7>   LVCMOS25_S_12mA_O
P6   vsync   LVCMOS25_S_12mA_O
R11   blue<0>   LVCMOS25_S_12mA_O
V12   blue<1>   LVCMOS25_S_12mA_O
R12   blue<2>   LVCMOS25_S_12mA_O
R13   blue<3>   LVCMOS25_S_12mA_O
P11   blue<4>   LVCMOS25_S_12mA_O
C2   IO_L01P_7/VRN_7   NC
C3   IO_L01N_7/VRP_7   NC
B1   IO_L16P_7/VREF_7   NC
C1   IO_L16N_7   NC
D2   IO_L17P_7   NC
D1   IO_L17N_7   NC
D3   IO_L19P_7   NC
E3   IO_L19N_7/VREF_7   NC
E1   IO_L20P_7   NC
E2   IO_L20N_7   NC
F4   IO_L21P_7   NC
E4   IO_L21N_7   NC
F5   IO_L22P_7   NC
G5   IO_L22N_7   NC
F2   IO_L23P_7   NC
G1   IO_L23N_7   NC
G3   IO_L24P_7   NC
G4   IO_L24N_7   NC
H6   IO_L27P_7/VREF_7   NC
H5   IO_L27N_7   NC
H3   IO_L34P_7   NC
H4   IO_L34N_7   NC
H2   IO_L35P_7   NC
H1   IO_L35N_7   NC
J6   IO   NC
J2   IO_L39P_7   NC
J1   IO_L39N_7   NC
J4   IO_L40P_7   NC
J5   IO_L40N_7/VREF_7   NC
K2   IO_L40P_6/VREF_6   NC
K1   IO_L40N_6   NC
K4   IO_L39P_6   NC
K5   IO_L39N_6   NC
K6   IO   NC
L1   IO_L35P_6   NC
L2   IO_L35N_6   NC
L4   IO_L34P_6   NC
L3   IO_L34N_6/VREF_6   NC
L5   IO_L27P_6   NC
L6   IO_L27N_6   NC
M1   IO_L24P_6   NC
N2   IO_L24N_6/VREF_6   NC
M4   IO_L23P_6   NC
M3   IO_L23N_6   NC
M5   IO_L22P_6   NC
N5   IO_L22N_6   NC
P4   IO_L21P_6   NC
N4   IO_L21N_6   NC
P1   IO_L20P_6   NC
P2   IO_L20N_6   NC
T2   IO_L01P_6/VRN_6   NC
T3   IO_L01N_6/VRP_6   NC
U3   M1   LVCMOS25_F_12mA
P5   M0   LVCMOS25_F_12mA
R4   M2   LVCMOS25_F_12mA
V2   CS_B   LVCMOS25_F_12mA
T4   IO_L06P_5   NC
U4   IO_L10P_5/VRN_5   NC
V4   IO_L10N_5/VRP_5   NC
R5   IO_L15P_5   NC
U5   IO_L16P_5   NC
V5   IO_L16N_5   NC
U6   IO   NC
T8   IO_L30P_5   NC
R8   IO_L30N_5   NC
N8   IO   NC
V9   D5   LVCMOS25_F_12mA
U9   D4   LVCMOS25_F_12mA
P9   GCLK2   LVCMOS25_F_12mA
N9   GCLK3   LVCMOS25_F_12mA
R9   IO/VREF_5   NC
N10   GCLK1   LVCMOS25_F_12mA
R10   IO/VREF_4   NC
N11   D2   LVCMOS25_F_12mA
P13   IO_L25P_4   NC
V14   IO   NC
U14   IO_L10P_4   NC
T14   IO_L10N_4   NC
V15   IO_L09P_4   NC
U15   IO_L09N_4   NC
R14   IO_L06P_4   NC
P14   IO_L06N_4/VREF_4   NC
V16   IO_L01P_4/VRN_4   NC
U16   IO_L01N_4/VRP_4   NC
V17   IO/VREF_4   NC
R15   DONE   LVCMOS25_F_12mA
T15   CCLK   LVCMOS25_S_12mA
T16   IO_L01P_3/VRN_3   NC
T17   IO_L01N_3/VRP_3   NC
U18   IO_L16P_3   NC
T18   IO_L16N_3   NC
R16   IO_L17P_3/VREF_3   NC
P16   IO_L17N_3   NC
R18   IO_L19P_3   NC
R17   IO_L19N_3   NC
P17   IO_L20P_3   NC
P18   IO_L20N_3   NC
N15   IO_L21P_3   NC
P15   IO_L21N_3   NC
N14   IO_L22P_3   NC
M14   IO_L22N_3   NC
M16   IO_L23P_3/VREF_3   NC
M15   IO_L23N_3   NC
N17   IO_L24P_3   NC
M18   IO_L24N_3   NC
L13   IO_L27P_3   NC
L14   IO_L27N_3   NC
L16   IO_L34P_3/VREF_3   NC
L15   IO_L34N_3   NC
L17   IO_L35P_3   NC
L18   IO_L35N_3   NC
K15   IO   NC
K14   IO_L39P_3   NC
K13   IO_L39N_3   NC
K18   IO_L40P_3   NC
K17   IO_L40N_3/VREF_3   NC
J14   IO_L40P_2/VREF_2   NC
J15   IO_L40N_2   NC
J17   IO_L39P_2   NC
J18   IO_L39N_2   NC
J13   IO   NC
H18   IO_L35P_2   NC
H17   IO_L35N_2   NC
H15   IO_L34P_2   NC
H16   IO_L34N_2/VREF_2   NC
H14   IO_L27P_2   NC
H13   IO_L27N_2   NC
G16   IO_L24P_2   NC
G15   IO_L24N_2   NC
F17   IO_L23P_2   NC
G18   IO_L23N_2/VREF_2   NC
G14   IO_L22P_2   NC
F14   IO_L22N_2   NC
E15   IO_L21P_2   NC
F15   IO_L21N_2   NC
E18   IO_L20P_2   NC
E17   IO_L20N_2   NC
E16   IO_L19P_2   NC
D16   IO_L19N_2   NC
D18   IO_L17P_2/VREF_2   NC
D17   IO_L17N_2   NC
C18   IO_L16P_2   NC
B18   IO_L16N_2   NC
C17   IO_L01P_2/VRN_2   NC
C16   IO_L01N_2/VRP_2   NC
D15   TDO   LVCMOS25_F_12mA
E14   TCK   LVCMOS25_F_12mA
B16   TMS   LVCMOS25_F_12mA
A17   IO_L01P_1/VRN_1   NC
A16   IO_L01N_1/VRP_1   NC
B15   IO_L10P_1   NC
A15   IO_L10N_1/VREF_1   NC
C15   IO_L15P_1   NC
C14   IO_L15N_1   NC
B14   IO_L16P_1   NC
A14   IO_L16N_1   NC
D13   IO_L24P_1   NC
D14   IO_L24N_1   NC
B13   IO   NC
E12   IO_L27P_1   NC
E13   IO_L27N_1   NC
D12   IO_L28P_1   NC
C12   IO_L28N_1   NC
A12   IO/VREF_1   NC
E11   IO_L29P_1   NC
F11   IO_L29N_1   NC
D11   IO_L30P_1   NC
C11   IO_L30N_1   NC
A11   IO   NC
B10   IO_L31P_1   NC
A10   IO_L31N_1/VREF_1   NC
F10   GCLK4   LVCMOS25_F_12mA
E10   GCLK5   LVCMOS25_F_12mA
D10   IO   NC
F9   GCLK6   LVCMOS25_F_12mA
E9   GCLK7   LVCMOS25_F_12mA
A9   IO_L31P_0/VREF_0   NC
B9   IO_L31N_0   NC
D9   IO   NC
A8   IO_L30P_0   NC
A7   IO_L30N_0   NC
F8   IO_L29P_0   NC
E8   IO_L29N_0   NC
D8   IO_L28P_0   NC
C8   IO_L28N_0   NC
D7   IO_L27P_0   NC
C7   IO_L27N_0   NC
E7   IO   NC
B6   IO_L25P_0   NC
B5   IO_L25N_0   NC
D6   IO/VREF_0   NC
A5   IO_L15P_0   NC
A4   IO_L15N_0   NC
D5   IO_L10P_0   NC
C5   IO_L10N_0   NC
C4   IO_L09P_0   NC
B4   IO_L09N_0   NC
A3   IO_L01P_0/VRN_0   NC
A2   IO_L01N_0/VRP_0   NC
B3   IO/VREF_0   NC
E6   HSWAP_EN   LVCMOS25_F_12mA
E5   PROG_B   LVCMOS25_F_12mA
D4   TDI   LVCMOS25_F_12mA
F1   GND   GND
N1   GND   GND
V1   GND   GND
B2   GND   GND
U2   GND   GND
J3   GND   GND
K3   GND   GND
A6   GND   GND
V6   GND   GND
G7   GND   GND
M7   GND   GND
H8   GND   GND
J8   GND   GND
K8   GND   GND
L8   GND   GND
C9   GND   GND
H9   GND   GND
L9   GND   GND
T9   GND   GND
C10   GND   GND
H10   GND   GND
L10   GND   GND
T10   GND   GND
H11   GND   GND
J11   GND   GND
K11   GND   GND
L11   GND   GND
G12   GND   GND
M12   GND   GND
A13   GND   GND
V13   GND   GND
J16   GND   GND
K16   GND   GND
B17   GND   GND
U17   GND   GND
A18   GND   GND
F18   GND   GND
N18   GND   GND
V18   GND   GND
A1   GND   GND
G2   VCCAUX   POWER
M2   VCCAUX   POWER
B7   VCCAUX   POWER
U7   VCCAUX   POWER
B12   VCCAUX   POWER
U12   VCCAUX   POWER
G17   VCCAUX   POWER
M17   VCCAUX   POWER
C6   VCCO_0   POWER
B8   VCCO_0   POWER
G8   VCCO_0   POWER
G9   VCCO_0   POWER
G10   VCCO_1   POWER
B11   VCCO_1   POWER
G11   VCCO_1   POWER
C13   VCCO_1   POWER
H12   VCCO_2   POWER
J12   VCCO_2   POWER
F16   VCCO_2   POWER
K12   VCCO_3   POWER
L12   VCCO_3   POWER
N16   VCCO_3   POWER
M10   VCCO_4   POWER
M11   VCCO_4   POWER
U11   VCCO_4   POWER
T13   VCCO_4   POWER
T6   VCCO_5   POWER
M8   VCCO_5   POWER
U8   VCCO_5   POWER
M9   VCCO_5   POWER
N3   VCCO_6   POWER
K7   VCCO_6   POWER
L7   VCCO_6   POWER
F3   VCCO_7   POWER
H7   VCCO_7   POWER
J7   VCCO_7   POWER
F6   VCCINT   POWER
G6   VCCINT   POWER
M6   VCCINT   POWER
N6   VCCINT   POWER
F7   VCCINT   POWER
N7   VCCINT   POWER
F12   VCCINT   POWER
N12   VCCINT   POWER
F13   VCCINT   POWER
G13   VCCINT   POWER
M13   VCCINT   POWER
N13   VCCINT   POWER
[Diff Pin]   inv_pin   vdiff   tdelay_typ   tdelay_min   tdelay_max
| Models and submodels in the file (4): LVCMOS25_F_12mA (I/O), LVCMOS25_S_12mA (I/O), LVCMOS25_S_12mA_I (Input), LVCMOS25_S_12mA_O (Output)
